* Single SKY130 NMOS transistor - DC operating point test
.lib "C:/Users/Kio/.ciel/ciel/sky130/versions/bdc9412b3e468c102d01b7cf6337be06ec6e9c9a/sky130A/libs.tech/ngspice/sky130.lib.spice" tt

Vdd vdd 0 1.8
Vgate gate 0 0.9
XM1 vdd gate 0 0 sky130_fd_pr__nfet_01v8 w=1 l=0.15

.control
op
print v(vdd) i(Vdd)
.endc
.end
