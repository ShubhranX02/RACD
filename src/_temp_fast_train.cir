Combined AC/OP/Noise (fast training mode)
.lib "/Users/shubhransharma/.ciel/ciel/sky130/versions/bdc9412b3e468c102d01b7cf6337be06ec6e9c9a/sky130A/libs.tech/ngspice/sky130.lib.spice" tt
.option temp=27
.option scale=1u

Vdd vdd 0 1.8
Vinp vin_p 0 DC 0.9 AC 0.5
Vinn vin_n 0 DC 0.9 AC -0.5

XM1 voutn vin_p s1 0 sky130_fd_pr__nfet_01v8 w=4.571473121643066 l=0.15
XM2 voutp vin_n s2 0 sky130_fd_pr__nfet_01v8 w=4.571473121643066 l=0.15

Rs s1 s2 622.1697998046875
Cs s1 s2 9.9999998245167e-14

Itail1 s1 0 DC 986.492919921875u
Itail2 s2 0 DC 986.492919921875u

RL1 vdd voutn 654.9639892578125
RL2 vdd voutp 654.9639892578125

* 1-Tap DFE (Fully Differential)
Bslice_p vslice_p 0 V = V(voutp,voutn) > 0 ? 0.1 : -0.1
Bslice_n vslice_n 0 V = V(voutp,voutn) < 0 ? 0.1 : -0.1
Tdelay_p vslice_p 0 vdelayed_p 0 Z0=50 TD=200p
Tdelay_n vslice_n 0 vdelayed_n 0 Z0=50 TD=200p
Rdfe1 vdelayed_p voutp 41052.875
Rdfe2 vdelayed_n voutn 41052.875

.control
ac dec 10 10meg 10g
wrdata /Users/shubhransharma/IITB/RACD/src/_temp_ac_data vdb(voutp,voutn)

op
print i(Vdd)

noise v(voutp,voutn) vinp dec 10 10meg 5g
print inoise_total
.endc
.end
