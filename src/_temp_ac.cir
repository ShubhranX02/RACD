Passive CTLE - AC Analysis
Vin in 0 AC 1

Rs in mid 449.5925598144531
Cs in mid 9.136131955134186e-12
RL mid 0 200

.control
ac dec 20 1meg 10g
wrdata _temp_ac_data vdb(mid)
.endc
.end
